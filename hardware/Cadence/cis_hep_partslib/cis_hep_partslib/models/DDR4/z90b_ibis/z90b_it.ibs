| z90b_it.ibs * IBIS 5.0 Model
| 4Gb DDR4 SDRAM - Die Revision "B"
| This Model is valid for Industrial Temperature Range -40C<=Tc<=95C
| Valid for DDR4-1600/1866/2133/2400/2666/3200 operation
| Models *_3200 are applicable for speed grade 3200 Mbps (-062) and below
| Part Number   VDD/VDDQ   Architecture   Package
| MT40A1G4RH   1.2V/1.2V   1Gb   x 4   78-Ball FBGA
| MT40A512M8RH   1.2V/1.2V   512Mb x 8   78-Ball FBGA
| MT40A256M16GE   1.2V/1.2V   256Mb x 16   96-Ball FBGA
| MT40A1G4Z90B   1.2V/1.2V   1Gb   x 4   Bare Die
| MT40A512M8Z90B   1.2V/1.2V   512Mb x 8   Bare Die
| MT40A256M16Z90B   1.2V/1.2V   256Mb x 16   Bare Die
[IBIS Ver]   5.0
[File Name]   z90b_it.ibs
[Date]   4/4/2018
[File Rev]   2.1
[Source]   From silicon level SPICE model at Micron Technology, Inc.
   For support e-mail modelsupport@micron.com
[Notes]   Revision History:
   Rev 1.0: 12/9/2015
   - Initial pre-silicon model
   - Model data extracted from HSPICE model revision 1.0
   Rev 2.0: 4/3/2017
   - Matched C_comp with latest IOCAP measurements
   - Matched IV curves with latest silicon measurements
   Rev 2.1: 4/4/2018
   - Fixed Pin section for x4 component
   Notes:
   - This IBIS file uses the Submodel keyword to model the
   DDR4 On-die Termination(ODT) characteristics.
   - The C_comp value in the DQ I/O model is set to match the
   input state of the DQ I/O as measured from the HSPICE model.
   The C_comp value decreases in the DQ/DQS Input ODT models.
   - L_pin values in the Pin sections are loop inductance and
   include the mutual inductance to appropriate POWER/GND
   return paths.  POWER/GND parasitics are modeled in the
   Package Models.
   - Typ and slow corner V-t curves in the following DQ* models
   are shifted relative to strong corner V-t curve
   to contain all 3 corners within appropriate V-t window
   Models   Typ   Slow   V-t duration
   DQ*_34_2666   -150ps   -400ps   750ps
   DQ*_40_2666   -150ps   -400ps   750ps
   DQ*_48_2666   -150ps   -400ps   750ps
   DQ*_34_3200   -50ps   -100ps   625ps
   DQ*_40_3200   -50ps   -100ps   625ps
   DQ*_48_3200   -50ps   -100ps   625ps
   ALERT_2666   -150ps   -400ps   500ps
   ALERT_3200   -50ps   -100ps   500ps
   - Due to the shift in typ and slow corner, the V-t curves
   may overlap each other. This does not effect the accuracy
   of the IBIS data.
   - The NF_INPUT Model is for Non-functioning pins in the x4
   package
   - IBIS Quality Specification 2.0 Summary:
   IQ Score: IQ3MSX
   See Micron IBIS Model Quality Report and Quality Checklist
   for full IQ details
[Disclaimer]  This software code and all associated documentation, comments
              or other information (collectively "Software") is provided
              "AS IS" without warranty of any kind. MICRON TECHNOLOGY, INC.
              ("MTI") EXPRESSLY DISCLAIMS ALL WARRANTIES EXPRESS OR IMPLIED,
              INCLUDING BUT NOT LIMITED TO, NONINFRINGEMENT OF THIRD PARTY
              RIGHTS, AND ANY IMPLIED WARRANTIES OF MERCHANTABILITY OR
              FITNESS FOR ANY PARTICULAR PURPOSE. MTI DOES NOT WARRANT THAT
              THE SOFTWARE WILL MEET YOUR REQUIREMENTS, OR THAT THE
              OPERATION OF THE SOFTWARE WILL BE UNINTERRUPTED OR ERROR-FREE.
              FURTHERMORE, MTI DOES NOT MAKE ANY REPRESENTATIONS REGARDING
              THE USE OR THE RESULTS OF THE USE OF THE SOFTWARE IN TERMS OF
              ITS CORRECTNESS, ACCURACY, RELIABILITY, OR OTHERWISE. THE
              ENTIRE RISK ARISING OUT OF USE OR PERFORMANCE OF THE SOFTWARE
              REMAINS WITH YOU. IN NO EVENT SHALL MTI, ITS AFFILIATED
              COMPANIES OR THEIR SUPPLIERS BE LIABLE FOR ANY DIRECT,
              INDIRECT, CONSEQUENTIAL, INCIDENTAL, OR SPECIAL DAMAGES
              (INCLUDING, WITHOUT LIMITATION, DAMAGES FOR LOSS OF PROFITS,
              BUSINESS INTERRUPTION, OR LOSS OF INFORMATION) ARISING OUT OF
              YOUR USE OF OR INABILITY TO USE THE SOFTWARE, EVEN IF MTI HAS
              BEEN ADVISED OF THE POSSIBILITY OF SUCH DAMAGES. Because some
              jurisdictions prohibit the exclusion or limitation of
              liability for consequential or incidental damages, the above
              limitation may not apply to you.
[Copyright]   Copyright 2018 Micron Technology, Inc. All rights reserved.
| COMPONENT: MT40A1G4RH (78-Ball FBGA, x4)
[Component]   MT40A1G4RH
[Package Model] z90b_78ball_pkg
[Manufacturer]  Micron Technology,Inc.
[Package]
|   typ   min   max
R_pkg   0.386   0.215   0.647
L_pkg   1.778nH   1.019nH   3.083nH
C_pkg   0.434pF   0.295pF   0.714pF
[Pin]   signal_name   model_name   R_pin   L_pin   C_pin   | TD_pin(ps)   Z_pin
A1   VDD   POWER
A2   VSSQ   GND
A3   NF   NF_INPUT   0.392   1.552nH   0.433pF   |  25.933   59.829
A7   NF   NF_INPUT   0.456   1.821nH   0.506pF   |  30.363   59.983
A8   VSSQ   GND
A9   VSS   GND
B1   VPP   POWER
B2   VDDQ   POWER
B3   DQS_c   DQS   0.403   1.781nH   0.452pF   |  28.387   62.746
B7   DQ1   DQ   0.457   1.726nH   0.484pF   |  28.890   59.741
B8   VDDQ   POWER
B9   ZQ   NC
C1   VDDQ   POWER
C2   DQ0   DQ   0.439   1.685nH   0.507pF   |  29.224   57.669
C3   DQS_t   DQS   0.420   1.785nH   0.463pF   |  28.733   62.115
C7   VDD   POWER
C8   VSS   GND
C9   VDDQ   POWER
D1   VSS   GND
D2   NC   NC
D3   DQ2   DQ   0.396   1.589nH   0.445pF   |  26.598   59.753
D7   DQ3   DQ   0.409   1.664nH   0.432pF   |  26.796   62.085
D8   NC   NC
D9   VSS   GND
E1   VSSDLL   GND
E2   VDDQ   POWER
E3   NC   NC
E7   NC   NC
E8   VDDQ   POWER
E9   VSS   GND
F1   VDDDLL   POWER
F2   NC   NC
F3   ODT   INPUT   0.300   1.490nH   0.381pF   |  23.823   62.552
F7   CK_t   CLKIN   0.345   1.513nH   0.377pF   |  23.886   63.345
F8   CK_c   CLKIN   0.347   1.500nH   0.409pF   |  24.774   60.548
F9   VDD   POWER
G1   VSS   GND
G2   NC   NC
G3   CKE   INPUT   0.215   1.067nH   0.295pF   |  17.732   60.151
G7   CS_n   INPUT   0.256   1.127nH   0.332pF   |  19.338   58.280
G8   NC   NC
G9   TEN   TEN   0.647   3.083nH   0.714pF   |  46.903   65.724
H1   VDD   POWER
H2   WE_n_A14   INPUT   0.336   1.575nH   0.382pF   |  24.525   64.230
H3   ACT_n   INPUT   0.352   1.548nH   0.348pF   |  23.209   66.710
H7   CAS_n_A15   INPUT   0.231   1.019nH   0.307pF   |  17.676   57.638
H8   RAS_n_A16   INPUT   0.338   1.497nH   0.385pF   |  24.002   62.354
H9   VSS   GND
J1   VREFCA   POWER
J2   BG0   INPUT   0.363   1.756nH   0.437pF   |  27.687   63.421
J3   A10   INPUT   0.404   1.820nH   0.395pF   |  26.803   67.908
J7   A12   INPUT   0.397   1.891nH   0.386pF   |  27.015   69.992
J8   BG1   INPUT   0.339   1.462nH   0.412pF   |  24.535   59.574
J9   VDD   POWER
K1   VSS   GND
K2   BA0   INPUT   0.359   1.685nH   0.421pF   |  26.621   63.300
K3   A4   INPUT   0.406   1.901nH   0.374pF   |  26.680   71.262
K7   A3   INPUT   0.283   1.285nH   0.368pF   |  21.752   59.086
K8   BA1   INPUT   0.356   1.735nH   0.425pF   |  27.155   63.902
K9   VSS   GND
L1   RESET_n   RESET   0.448   2.307nH   0.513pF   |  34.410   67.042
L2   A6   INPUT   0.372   1.982nH   0.416pF   |  28.724   68.985
L3   A0   INPUT   0.404   2.075nH   0.378pF   |  27.992   74.119
L7   A1   INPUT   0.438   2.160nH   0.399pF   |  29.368   73.545
L8   A5   INPUT   0.383   1.722nH   0.440pF   |  27.524   62.561
L9   ALERT_n   ALERT   0.312   1.809nH   0.637pF   |  33.954   53.281
M1   VDD   POWER
M2   A8   INPUT   0.400   2.140nH   0.444pF   |  30.819   69.443
M3   A2   INPUT   0.340   1.847nH   0.394pF   |  26.977   68.451
M7   A9   INPUT   0.341   1.829nH   0.375pF   |  26.205   69.805
M8   A7   INPUT   0.405   2.185nH   0.434pF   |  30.779   70.982
M9   VPP   POWER
N1   VSS   GND
N2   A11   INPUT   0.453   2.507nH   0.454pF   |  33.721   74.350
N3   PARITY   INPUT   0.392   2.126nH   0.403pF   |  29.266   72.627
N7   NC   NC
N8   A13   INPUT   0.464   2.484nH   0.436pF   |  32.923   75.448
N9   VDD   POWER
|***********************PIN MAPPING*****************************************
[Pin Mapping]   pulldown_ref   pullup_ref   gnd_clamp_ref   power_clamp_ref ext_ref
A1   NC   VDD
A2   VSS   NC
A3   NC   NC   VSS   VDDQ
A7   NC   NC   VSS   VDDQ
A8   VSS   NC
A9   VSS   NC
B1   NC   VPP
B2   NC   VDDQ
B3   VSS   VDDQ   VSS   VDDQ
B7   VSS   VDDQ   VSS   VDDQ
B8   NC   VDDQ
B9   NC   NC
C1   NC   VDDQ
C2   VSS   VDDQ   VSS   VDDQ
C3   VSS   VDDQ   VSS   VDDQ
C7   NC   VDD
C8   VSS   NC
C9   NC   VDDQ
D1   VSS   NC
D2   NC   NC
D3   VSS   VDDQ   VSS   VDDQ
D7   VSS   VDDQ   VSS   VDDQ
D8   NC   NC
D9   VSS   NC
E1   VSSDLL   NC
E2   NC   VDDQ
E3   NC   NC
E7   NC   NC
E8   NC   VDDQ
E9   VSS   NC
F1   NC   VDDDLL
F2   NC   NC
F3   NC   NC   VSS   VDD
F7   NC   NC   VSS   VDD
F8   NC   NC   VSS   VDD
F9   NC   VDD
G1   VSS   NC
G2   NC   NC
G3   NC   NC   VSS   VDD
G7   NC   NC   VSS   VDD
G8   NC   NC
G9   NC   NC   VSS   VDD
H1   NC   VDD
H2   NC   NC   VSS   VDD
H3   NC   NC   VSS   VDD
H7   NC   NC   VSS   VDD
H8   NC   NC   VSS   VDD
H9   VSS   NC
J1   NC   VREFCA
J2   NC   NC   VSS   VDD
J3   NC   NC   VSS   VDD
J7   NC   NC   VSS   VDD
J8   NC   NC   VSS   VDD
J9   NC   VDD
K1   VSS   NC
K2   NC   NC   VSS   VDD
K3   NC   NC   VSS   VDD
K7   NC   NC   VSS   VDD
K8   NC   NC   VSS   VDD
K9   VSS   NC
L1   NC   NC   VSS   VDD
L2   NC   NC   VSS   VDD
L3   NC   NC   VSS   VDD
L7   NC   NC   VSS   VDD
L8   NC   NC   VSS   VDD
L9   VSS   VDDQ   VSS   VDDQ
M1   NC   VDD
M2   NC   NC   VSS   VDD
M3   NC   NC   VSS   VDD
M7   NC   NC   VSS   VDD
M8   NC   NC   VSS   VDD
M9   NC   VPP
N1   VSS   NC
N2   NC   NC   VSS   VDD
N3   NC   NC   VSS   VDD
N7   NC   NC
N8   NC   NC   VSS   VDD
N9   NC   VDD
|**********************DIFF PIN*********************************************
[Diff_pin]   inv_pin   vdiff   tdelay_typ   tdelay_min   tdelay_max
   C3   B3   0.000V   0ns   NA   NA
   F7   F8   0.250V   0ns   NA   NA
| COMPONENT: MT40A512M8RH (78-Ball FBGA, x8)
[Component]   MT40A512M8RH
[Package Model] z90b_78ball_pkg
[Manufacturer]  Micron Technology,Inc.
[Package]
|   typ   min   max
R_pkg   0.386   0.215   0.647
L_pkg   1.778nH   1.019nH   3.083nH
C_pkg   0.434pF   0.295pF   0.714pF
[Pin]   signal_name   model_name   R_pin   L_pin   C_pin   | TD_pin(ps)   Z_pin
A1   VDD   POWER
A2   VSSQ   GND
A3   TDQS_c   NF_TDQS   0.392   1.552nH   0.433pF   |  25.933   59.829
A7   DM_n_DBI_n_TDQS_t   DM_DBI_TDQS   0.456   1.821nH   0.506pF   |  30.363   59.983
A8   VSSQ   GND
A9   VSS   GND
B1   VPP   POWER
B2   VDDQ   POWER
B3   DQS_c   DQS   0.403   1.781nH   0.452pF   |  28.387   62.746
B7   DQ1   DQ   0.457   1.726nH   0.484pF   |  28.890   59.741
B8   VDDQ   POWER
B9   ZQ   NC
C1   VDDQ   POWER
C2   DQ0   DQ   0.439   1.685nH   0.507pF   |  29.224   57.669
C3   DQS_t   DQS   0.420   1.785nH   0.463pF   |  28.733   62.115
C7   VDD   POWER
C8   VSS   GND
C9   VDDQ   POWER
D1   VSS   GND
D2   DQ4   DQ   0.408   1.600nH   0.485pF   |  27.871   57.414
D3   DQ2   DQ   0.396   1.589nH   0.445pF   |  26.598   59.753
D7   DQ3   DQ   0.409   1.664nH   0.432pF   |  26.796   62.085
D8   DQ5   DQ   0.407   1.541nH   0.486pF   |  27.372   56.297
D9   VSS   GND
E1   VSSDLL   GND
E2   VDDQ   POWER
E3   DQ6   DQ   0.407   1.593nH   0.478pF   |  27.587   57.740
E7   DQ7   DQ   0.408   1.681nH   0.443pF   |  27.288   61.588
E8   VDDQ   POWER
E9   VSS   GND
F1   VDDDLL   POWER
F2   NC   NC
F3   ODT   INPUT   0.300   1.490nH   0.381pF   |  23.823   62.552
F7   CK_t   CLKIN   0.345   1.513nH   0.377pF   |  23.886   63.345
F8   CK_c   CLKIN   0.347   1.500nH   0.409pF   |  24.774   60.548
F9   VDD   POWER
G1   VSS   GND
G2   NC   NC
G3   CKE   INPUT   0.215   1.067nH   0.295pF   |  17.732   60.151
G7   CS_n   INPUT   0.256   1.127nH   0.332pF   |  19.338   58.280
G8   NC   NC
G9   TEN   TEN   0.647   3.083nH   0.714pF   |  46.903   65.724
H1   VDD   POWER
H2   WE_n_A14   INPUT   0.336   1.575nH   0.382pF   |  24.525   64.230
H3   ACT_n   INPUT   0.352   1.548nH   0.348pF   |  23.209   66.710
H7   CAS_n_A15   INPUT   0.231   1.019nH   0.307pF   |  17.676   57.638
H8   RAS_n   INPUT   0.338   1.497nH   0.385pF   |  24.002   62.354
H9   VSS   GND
J1   VREFCA   POWER
J2   BG0   INPUT   0.363   1.756nH   0.437pF   |  27.687   63.421
J3   A10   INPUT   0.404   1.820nH   0.395pF   |  26.803   67.908
J7   A12   INPUT   0.397   1.891nH   0.386pF   |  27.015   69.992
J8   BG1   INPUT   0.339   1.462nH   0.412pF   |  24.535   59.574
J9   VDD   POWER
K1   VSS   GND
K2   BA0   INPUT   0.359   1.685nH   0.421pF   |  26.621   63.300
K3   A4   INPUT   0.406   1.901nH   0.374pF   |  26.680   71.262
K7   A3   INPUT   0.283   1.285nH   0.368pF   |  21.752   59.086
K8   BA1   INPUT   0.356   1.735nH   0.425pF   |  27.155   63.902
K9   VSS   GND
L1   RESET_n   RESET   0.448   2.307nH   0.513pF   |  34.410   67.042
L2   A6   INPUT   0.372   1.982nH   0.416pF   |  28.724   68.985
L3   A0   INPUT   0.404   2.075nH   0.378pF   |  27.992   74.119
L7   A1   INPUT   0.438   2.160nH   0.399pF   |  29.368   73.545
L8   A5   INPUT   0.383   1.722nH   0.440pF   |  27.524   62.561
L9   ALERT_n   ALERT   0.312   1.809nH   0.637pF   |  33.954   53.281
M1   VDD   POWER
M2   A8   INPUT   0.400   2.140nH   0.444pF   |  30.819   69.443
M3   A2   INPUT   0.340   1.847nH   0.394pF   |  26.977   68.451
M7   A9   INPUT   0.341   1.829nH   0.375pF   |  26.205   69.805
M8   A7   INPUT   0.405   2.185nH   0.434pF   |  30.779   70.982
M9   VPP   POWER
N1   VSS   GND
N2   A11   INPUT   0.453   2.507nH   0.454pF   |  33.721   74.350
N3   PARITY   INPUT   0.392   2.126nH   0.403pF   |  29.266   72.627
N7   NC   NC
N8   A13   INPUT   0.464   2.484nH   0.436pF   |  32.923   75.448
N9   VDD   POWER
|***********************PIN MAPPING*****************************************
[Pin Mapping]   pulldown_ref   pullup_ref   gnd_clamp_ref   power_clamp_ref ext_ref
A1   NC   VDD
A2   VSS   NC
A3   VSS   VDDQ   VSS   VDDQ
A7   VSS   VDDQ   VSS   VDDQ
A8   VSS   NC
A9   VSS   NC
B1   NC   VPP
B2   NC   VDDQ
B3   VSS   VDDQ   VSS   VDDQ
B7   VSS   VDDQ   VSS   VDDQ
B8   NC   VDDQ
B9   NC   NC
C1   NC   VDDQ
C2   VSS   VDDQ   VSS   VDDQ
C3   VSS   VDDQ   VSS   VDDQ
C7   NC   VDD
C8   VSS   NC
C9   NC   VDDQ
D1   VSS   NC
D2   VSS   VDDQ   VSS   VDDQ
D3   VSS   VDDQ   VSS   VDDQ
D7   VSS   VDDQ   VSS   VDDQ
D8   VSS   VDDQ   VSS   VDDQ
D9   VSS   NC
E1   VSSDLL   NC
E2   NC   VDDQ
E3   VSS   VDDQ   VSS   VDDQ
E7   VSS   VDDQ   VSS   VDDQ
E8   NC   VDDQ
E9   VSS   NC
F1   NC   VDDDLL
F2   NC   NC
F3   NC   NC   VSS   VDD
F7   NC   NC   VSS   VDD
F8   NC   NC   VSS   VDD
F9   NC   VDD
G1   VSS   NC
G2   NC   NC
G3   NC   NC   VSS   VDD
G7   NC   NC   VSS   VDD
G8   NC   NC
G9   NC   NC   VSS   VDD
H1   NC   VDD
H2   NC   NC   VSS   VDD
H3   NC   NC   VSS   VDD
H7   NC   NC   VSS   VDD
H8   NC   NC   VSS   VDD
H9   VSS   NC
J1   NC   VREFCA
J2   NC   NC   VSS   VDD
J3   NC   NC   VSS   VDD
J7   NC   NC   VSS   VDD
J8   NC   NC   VSS   VDD
J9   NC   VDD
K1   VSS   NC
K2   NC   NC   VSS   VDD
K3   NC   NC   VSS   VDD
K7   NC   NC   VSS   VDD
K8   NC   NC   VSS   VDD
K9   VSS   NC
L1   NC   NC   VSS   VDD
L2   NC   NC   VSS   VDD
L3   NC   NC   VSS   VDD
L7   NC   NC   VSS   VDD
L8   NC   NC   VSS   VDD
L9   VSS   VDDQ   VSS   VDDQ
M1   NC   VDD
M2   NC   NC   VSS   VDD
M3   NC   NC   VSS   VDD
M7   NC   NC   VSS   VDD
M8   NC   NC   VSS   VDD
M9   NC   VPP
N1   VSS   NC
N2   NC   NC   VSS   VDD
N3   NC   NC   VSS   VDD
N7   NC   NC
N8   NC   NC   VSS   VDD
N9   NC   VDD
|**********************DIFF PIN*********************************************
[Diff_pin]   inv_pin   vdiff   tdelay_typ   tdelay_min   tdelay_max
   C3   B3   0.000V   0ns   NA   NA
   F7   F8   0.250V   0ns   NA   NA
| COMPONENT: MT40A256M16GE (96-Ball FBGA, x16)
[Component]   MT40A256M16GE
[Package Model] z90b_96ball_pkg
[Manufacturer]  Micron Technology,Inc.
[Package]
|   typ   min   max
R_pkg   0.415   0.293   0.523
L_pkg   1.830nH   1.429nH   2.689nH
C_pkg   0.473pF   0.357pF   0.671pF
[Pin]   signal_name   model_name   R_pin   L_pin   C_pin   | TD_pin(ps)   Z_pin
A1   VDDQ   POWER
A2   VSSQ   GND
A3   DQ8   DQ   0.496   1.955nH   0.570pF   |  33.366   58.589
A7   UDQS_c   DQS   0.459   2.036nH   0.527pF   |  32.746   62.183
A8   VSSQ   GND
A9   VDDQ   POWER
B1   VPP   POWER
B2   VSS   GND
B3   VDD   POWER
B7   UDQS_t   DQS   0.466   2.043nH   0.534pF   |  33.026   61.861
B8   DQ9   DQ   0.487   1.876nH   0.557pF   |  32.330   58.030
B9   VDD   POWER
C1   VDDQ   POWER
C2   DQ12   DQ   0.523   2.051nH   0.542pF   |  33.329   61.543
C3   DQ10   DQ   0.451   1.777nH   0.464pF   |  28.719   61.886
C7   DQ11   DQ   0.455   1.833nH   0.488pF   |  29.903   61.290
C8   DQ13   DQ   0.476   1.772nH   0.561pF   |  31.522   56.206
C9   VSSQ   GND
D1   VDD   POWER
D2   VSSQ   GND
D3   DQ14   DQ   0.443   1.908nH   0.451pF   |  29.320   65.079
D7   DQ15   DQ   0.452   1.753nH   0.491pF   |  29.343   59.751
D8   VSSQ   GND
D9   VDDQ   POWER
E1   VSS   GND
E2   UDM_n_UDBI_n   DM_DBI   0.466   1.770nH   0.510pF   |  30.041   58.924
E3   VSSQ   GND
E7   LDM_n_LDBI_n   DM_DBI   0.414   1.543nH   0.453pF   |  26.444   58.363
E8   VSSQ   GND
E9   VSS   GND
F1   VSSQ   GND
F2   VDDQ   POWER
F3   LDQS_c   DQS   0.408   1.562nH   0.411pF   |  25.351   61.620
F7   DQ1   DQ   0.404   1.550nH   0.416pF   |  25.389   61.053
F8   VDDQ   POWER
F9   ZQ   NC
G1   VDDQ   POWER
G2   DQ0   DQ   0.411   1.528nH   0.451pF   |  26.255   58.184
G3   LDQS_t   DQS   0.404   1.631nH   0.424pF   |  26.285   62.050
G7   VDD   POWER
G8   VSS   GND
G9   VDDQ   POWER
H1   VSSQ   GND
H2   DQ4   DQ   0.432   1.632nH   0.491pF   |  28.321   57.629
H3   DQ2   DQ   0.419   1.681nH   0.410pF   |  26.241   64.079
H7   DQ3   DQ   0.400   1.562nH   0.425pF   |  25.748   60.652
H8   DQ5   DQ   0.440   1.674nH   0.482pF   |  28.416   58.926
H9   VSSQ   GND
J1   VDDDLL   POWER
J2   VDDQ   POWER
J3   DQ6   DQ   0.399   1.619nH   0.416pF   |  25.941   62.417
J7   DQ7   DQ   0.398   1.579nH   0.410pF   |  25.445   62.035
J8   VDDQ   POWER
J9   VDD   POWER
K1   VSSDLL   GND
K2   CKE   INPUT   0.367   1.673nH   0.434pF   |  26.937   62.114
K3   ODT   INPUT   0.352   1.572nH   0.383pF   |  24.550   64.047
K7   CK_t   CLKIN   0.367   1.523nH   0.408pF   |  24.936   61.059
K8   CK_c   CLKIN   0.380   1.591nH   0.454pF   |  26.878   59.190
K9   VSS   GND
L1   VDD   POWER
L2   WE_n_A14   INPUT   0.380   1.679nH   0.457pF   |  27.690   60.621
L3   ACT_n   INPUT   0.361   1.494nH   0.384pF   |  23.953   62.365
L7   CS_n   INPUT   0.346   1.534nH   0.388pF   |  24.404   62.876
L8   RAS_n   INPUT   0.378   1.711nH   0.447pF   |  27.651   61.866
L9   VDD   POWER
M1   VREFCA   POWER
M2   BG0   INPUT   0.381   1.840nH   0.442pF   |  28.521   64.512
M3   A10   INPUT   0.369   1.609nH   0.396pF   |  25.242   63.734
M7   A12_BC_n   INPUT   0.351   1.516nH   0.397pF   |  24.551   61.767
M8   CAS_n_A15   INPUT   0.402   1.698nH   0.478pF   |  28.500   59.565
M9   VSS   GND
N1   VSS   GND
N2   BA0   INPUT   0.382   1.836nH   0.435pF   |  28.269   64.946
N3   A4   INPUT   0.293   1.429nH   0.357pF   |  22.592   63.232
N7   A3   INPUT   0.373   1.703nH   0.431pF   |  27.105   62.843
N8   BA1   INPUT   0.395   1.913nH   0.487pF   |  30.542   62.651
N9   TEN   TEN   0.473   2.208nH   0.564pF   |  35.292   62.552
P1   RESET_n   RESET   0.503   2.519nH   0.561pF   |  37.607   66.990
P2   A6   INPUT   0.420   2.189nH   0.475pF   |  32.243   67.896
P3   A0   INPUT   0.326   1.750nH   0.375pF   |  25.620   68.328
P7   A1   INPUT   0.327   1.646nH   0.398pF   |  25.584   64.323
P8   A5   INPUT   0.430   1.917nH   0.505pF   |  31.102   61.625
P9   ALERT_n   ALERT   0.332   1.919nH   0.671pF   |  35.893   53.456
R1   VDD   POWER
R2   A8   INPUT   0.452   2.419nH   0.514pF   |  35.271   68.573
R3   A2   INPUT   0.383   2.082nH   0.471pF   |  31.310   66.487
R7   A9   INPUT   0.387   2.067nH   0.477pF   |  31.390   65.859
R8   A7   INPUT   0.477   2.410nH   0.557pF   |  36.650   65.764
R9   VPP   POWER
T1   VSS   GND
T2   A11   INPUT   0.509   2.689nH   0.607pF   |  40.419   66.542
T3   PARITY   INPUT   0.443   2.305nH   0.510pF   |  34.268   67.252
T7   NC   NC
T8   A13   INPUT   0.505   2.536nH   0.588pF   |  38.608   65.677
T9   VDD   POWER
|***********************PIN MAPPING*****************************************
[Pin Mapping]   pulldown_ref   pullup_ref   gnd_clamp_ref   power_clamp_ref ext_ref
A1   NC   VDDQ
A2   VSS   NC
A3   VSS   VDDQ   VSS   VDDQ
A7   VSS   VDDQ   VSS   VDDQ
A8   VSS   NC
A9   NC   VDDQ
B1   NC   VPP
B2   VSS   NC
B3   NC   VDD
B7   VSS   VDDQ   VSS   VDDQ
B8   VSS   VDDQ   VSS   VDDQ
B9   NC   VDD
C1   NC   VDDQ
C2   VSS   VDDQ   VSS   VDDQ
C3   VSS   VDDQ   VSS   VDDQ
C7   VSS   VDDQ   VSS   VDDQ
C8   VSS   VDDQ   VSS   VDDQ
C9   VSS   NC
D1   NC   VDD
D2   VSS   NC
D3   VSS   VDDQ   VSS   VDDQ
D7   VSS   VDDQ   VSS   VDDQ
D8   VSS   NC
D9   NC   VDDQ
E1   VSS   NC
E2   VSS   VDDQ   VSS   VDDQ
E3   VSS   NC
E7   VSS   VDDQ   VSS   VDDQ
E8   VSS   NC
E9   VSS   NC
F1   VSS   NC
F2   NC   VDDQ
F3   VSS   VDDQ   VSS   VDDQ
F7   VSS   VDDQ   VSS   VDDQ
F8   NC   VDDQ
F9   NC   NC
G1   NC   VDDQ
G2   VSS   VDDQ   VSS   VDDQ
G3   VSS   VDDQ   VSS   VDDQ
G7   NC   VDD
G8   VSS   NC
G9   NC   VDDQ
H1   VSS   NC
H2   VSS   VDDQ   VSS   VDDQ
H3   VSS   VDDQ   VSS   VDDQ
H7   VSS   VDDQ   VSS   VDDQ
H8   VSS   VDDQ   VSS   VDDQ
H9   VSS   NC
J1   NC   VDDDLL
J2   NC   VDDQ
J3   VSS   VDDQ   VSS   VDDQ
J7   VSS   VDDQ   VSS   VDDQ
J8   NC   VDDQ
J9   NC   VDD
K1   VSSDLL   NC
K2   NC   NC   VSS   VDD
K3   NC   NC   VSS   VDD
K7   NC   NC   VSS   VDD
K8   NC   NC   VSS   VDD
K9   VSS   NC
L1   NC   VDD
L2   NC   NC   VSS   VDD
L3   NC   NC   VSS   VDD
L7   NC   NC   VSS   VDD
L8   NC   NC   VSS   VDD
L9   NC   VDD
M1   NC   VREFCA
M2   NC   NC   VSS   VDD
M3   NC   NC   VSS   VDD
M7   NC   NC   VSS   VDD
M8   NC   NC   VSS   VDD
M9   VSS   NC
N1   VSS   NC
N2   NC   NC   VSS   VDD
N3   NC   NC   VSS   VDD
N7   NC   NC   VSS   VDD
N8   NC   NC   VSS   VDD
N9   NC   NC   VSS   VDD
P1   NC   NC   VSS   VDD
P2   NC   NC   VSS   VDD
P3   NC   NC   VSS   VDD
P7   NC   NC   VSS   VDD
P8   NC   NC   VSS   VDD
P9   VSS   VDDQ   VSS   VDDQ
R1   NC   VDD
R2   NC   NC   VSS   VDD
R3   NC   NC   VSS   VDD
R7   NC   NC   VSS   VDD
R8   NC   NC   VSS   VDD
R9   NC   VPP
T1   VSS   NC
T2   NC   NC   VSS   VDD
T3   NC   NC   VSS   VDD
T7   NC   NC
T8   NC   NC   VSS   VDD
T9   NC   VDD
|**********************DIFF PIN*********************************************
[Diff_pin]   inv_pin   vdiff   tdelay_typ   tdelay_min   tdelay_max
   B7   A7   0.000V   0ns   NA   NA
   G3   F3   0.000V   0ns   NA   NA
   K7   K8   0.250V   0ns   NA   NA
| COMPONENT: MT40A1G4Z90B (Bare Die, x4)
[Component]   MT40A1G4Z90B
[Manufacturer]  Micron Technology, Inc.
[Package]
|   typ   min   max
R_pkg   0.001m   0.001m   0.001m
L_pkg   0.001nH   0.001nH   0.001nH
C_pkg   0.001pF   0.001pF   0.001pF
[Pin]   signal_name   model_name   R_pin   L_pin   C_pin
1   VSS   GND
2   VDD   POWER
3   VPP   POWER
4   A13   INPUT
5   A9   INPUT
6   A7   INPUT
7   DNU   NC
8   A1   INPUT
9   ALERT_n   ALERT
10   A5   INPUT
11   VDD   POWER
12   VSS   GND
13   A3   INPUT
14   BA1   INPUT
15   TEN   TEN
16   A12   INPUT
17   BG1   INPUT
18   VSS   GND
19   DNU   NC
20   VSS   GND
21   CAS_n   INPUT
22   RAS_n   INPUT
23   CS_n   INPUT
24   VDD   POWER
25   VSS   GND
26   CLK_c   CLKIN
27   CLK_t   CLKIN
28   VSS   GND
29   VDD   POWER
30   VDD   POWER
31   VSS   GND
32   DNU   NC
33   VDDQ   POWER
34   DNU   NC
35   VSS   GND
36   DQ3   DQ
37   VDDQ   POWER
38   VDD   POWER
39   VSS   GND
40   ZQ   NC
41   VDDQ   POWER
42   DQ1   DQ
43   VSS   GND
44   LDM   DM_DBI
45   VDDQ   POWER
46   DNU   NC
47   VSS   GND
48   DNU   NC
49   DNU   NC
50   DNU   NC
51   VSS   GND
52   DNU   NC
53   DNU   NC
54   DNU   NC
55   VSS   GND
56   DNU   NC
57   DNU   NC
58   VSS   GND
59   VDD   POWER
60   VSS   GND
61   VPP   POWER
62   VDDQ   POWER
63   DNU   NC
64   DNU   NC
65   DNU   NC
66   DNU   NC
67   DNU   NC
68   DNU   NC
69   DNU   NC
70   DNU   NC
71   DNU   NC
72   VDDQ   POWER
73   DNU   NC
74   VSS   GND
75   VDD   POWER
76   DNU   NC
77   VDD   POWER
78   VSS   GND
79   LDQS_c   DQS
80   VDDQ   POWER
81   LDQS_t   DQS
82   VSS   GND
83   DQ0   DQ
84   VDDQ   POWER
85   DQ2   DQ
86   VSS   GND
87   DNU   NC
88   VDDQ   POWER
89   DNU   NC
90   VSS   GND
91   VDD   POWER
92   VSS   GND
93   ODT   INPUT
94   CKE   INPUT
95   WE_n   INPUT
96   VDDQ   POWER
97   ACT_n   INPUT
98   VDD   POWER
99   VREFCA   POWER
100   VSS   GND
101   DNU   NC
102   VSS   GND
103   A10   INPUT
104   BG0   INPUT
105   BA0   INPUT
106   VDD   POWER
107   A4   INPUT
108   RESET   RESET
109   A6   INPUT
110   DNU   NC
111   DNU   NC
112   DNU   NC
113   A0   INPUT
114   DNU   NC
115   A8   INPUT
116   A2   INPUT
117   A11   INPUT
118   PARITY   INPUT
|**********************DIFF PIN*********************************************
[Diff_pin]   inv_pin   vdiff   tdelay_typ   tdelay_min   tdelay_max
   27   26   0.250V   0ns   NA   NA
   81   79   0.000V   0ns   NA   NA
| COMPONENT: MT40A512M8Z90B (Bare Die, x8)
[Component]   MT40A512M8Z90B
[Manufacturer]  Micron Technology, Inc.
[Package]
|   typ   min   max
R_pkg   0.001m   0.001m   0.001m
L_pkg   0.001nH   0.001nH   0.001nH
C_pkg   0.001pF   0.001pF   0.001pF
[Pin]   signal_name   model_name   R_pin   L_pin   C_pin
1   VSS   GND
2   VDD   POWER
3   VPP   POWER
4   A13   INPUT
5   A9   INPUT
6   A7   INPUT
7   DNU   NC
8   A1   INPUT
9   ALERT_n   ALERT
10   A5   INPUT
11   VDD   POWER
12   VSS   GND
13   A3   INPUT
14   BA1   INPUT
15   TEN   TEN
16   A12   INPUT
17   BG1   INPUT
18   VSS   GND
19   DNU   NC
20   VSS   GND
21   CAS_n   INPUT
22   RAS_n   INPUT
23   CS_n   INPUT
24   VDD   POWER
25   VSS   GND
26   CLK_c   CLKIN
27   CLK_t   CLKIN
28   VSS   GND
29   VDD   POWER
30   VDD   POWER
31   VSS   GND
32   DQ7   DQ
33   VDDQ   POWER
34   DQ5   DQ
35   VSS   GND
36   DQ3   DQ
37   VDDQ   POWER
38   VDD   POWER
39   VSS   GND
40   ZQ   NC
41   VDDQ   POWER
42   DQ1   DQ
43   VSS   GND
44   LDM   DM_DBI
45   VDDQ   POWER
46   DNU   NC
47   VSS   GND
48   DNU   NC
49   DNU   NC
50   DNU   NC
51   VSS   GND
52   DNU   NC
53   DNU   NC
54   DNU   NC
55   VSS   GND
56   DNU   NC
57   DNU   NC
58   VSS   GND
59   VDD   POWER
60   VSS   GND
61   VPP   POWER
62   VDDQ   POWER
63   DNU   NC
64   DNU   NC
65   DNU   NC
66   DNU   NC
67   DNU   NC
68   DNU   NC
69   DNU   NC
70   DNU   NC
71   DNU   NC
72   VDDQ   POWER
73   DNU   NC
74   VSS   GND
75   VDD   POWER
76   DNU   NC
77   VDD   POWER
78   VSS   GND
79   LDQS_c   DQS
80   VDDQ   POWER
81   LDQS_t   DQS
82   VSS   GND
83   DQ0   DQ
84   VDDQ   POWER
85   DQ2   DQ
86   VSS   GND
87   DQ4   DQ
88   VDDQ   POWER
89   DQ6   DQ
90   VSS   GND
91   VDD   POWER
92   VSS   GND
93   ODT   INPUT
94   CKE   INPUT
95   WE_n   INPUT
96   VDDQ   POWER
97   ACT_n   INPUT
98   VDD   POWER
99   VREFCA   POWER
100   VSS   GND
101   DNU   NC
102   VSS   GND
103   A10   INPUT
104   BG0   INPUT
105   BA0   INPUT
106   VDD   POWER
107   A4   INPUT
108   RESET   RESET
109   A6   INPUT
110   DNU   NC
111   DNU   NC
112   DNU   NC
113   A0   INPUT
114   DNU   NC
115   A8   INPUT
116   A2   INPUT
117   A11   INPUT
118   PARITY   INPUT
|**********************DIFF PIN*********************************************
[Diff_pin]   inv_pin   vdiff   tdelay_typ   tdelay_min   tdelay_max
   27   26   0.250V   0ns   NA   NA
   81   79   0.000V   0ns   NA   NA
| COMPONENT: MT40A256M16Z90B (Bare Die, x16)
[Component]   MT40A256M16Z90B
[Manufacturer]  Micron Technology, Inc.
[Package]
|   typ   min   max
R_pkg   0.001m   0.001m   0.001m
L_pkg   0.001nH   0.001nH   0.001nH
C_pkg   0.001pF   0.001pF   0.001pF
[Pin]   signal_name   model_name   R_pin   L_pin   C_pin
1   VSS   GND
2   VDD   POWER
3   VPP   POWER
4   A13   INPUT
5   A9   INPUT
6   A7   INPUT
7   DNU   NC
8   A1   INPUT
9   ALERT_n   ALERT
10   A5   INPUT
11   VDD   POWER
12   VSS   GND
13   A3   INPUT
14   BA1   INPUT
15   TEN   TEN
16   A12   INPUT
17   DNU   NC
18   VSS   GND
19   DNU   NC
20   VSS   GND
21   CAS_n   INPUT
22   RAS_n   INPUT
23   CS_n   INPUT
24   VDD   POWER
25   VSS   GND
26   CLK_c   CLKIN
27   CLK_t   CLKIN
28   VSS   GND
29   VDD   POWER
30   VDD   POWER
31   VSS   GND
32   DQ7   DQ
33   VDDQ   POWER
34   DQ5   DQ
35   VSS   GND
36   DQ3   DQ
37   VDDQ   POWER
38   VDD   POWER
39   VSS   GND
40   ZQ   NC
41   VDDQ   POWER
42   DQ1   DQ
43   VSS   GND
44   LDM   DM_DBI
45   VDDQ   POWER
46   DNU   NC
47   VSS   GND
48   DQ15   DQ
49   VDDQ   POWER
50   DQ13   DQ
51   VSS   GND
52   DQ11   DQ
53   VDDQ   POWER
54   DQ9   DQ
55   VSS   GND
56   UDQS_t   DQS
57   UDQS_c   DQS
58   VSS   GND
59   VDD   POWER
60   VSS   GND
61   VPP   POWER
62   VDDQ   POWER
63   DQ8   DQ
64   VSS   GND
65   DQ10   DQ
66   VDDQ   POWER
67   DNU   NC
68   VDDQ   POWER
69   DQ12   DQ
70   VSS   GND
71   DQ14   DQ
72   VDDQ   POWER
73   UDM   DM_DBI
74   VSS   GND
75   DNU   NC
76   DNU   NC
77   VDD   POWER
78   VSS   GND
79   LDQS_c   DQS
80   VDDQ   POWER
81   LDQS_t   DQS
82   VSS   GND
83   DQ0   DQ
84   VDDQ   POWER
85   DQ2   DQ
86   VSS   GND
87   DQ4   DQ
88   VDDQ   POWER
89   DQ6   DQ
90   VSS   GND
91   VDD   POWER
92   VSS   GND
93   ODT   INPUT
94   CKE   INPUT
95   WE_n   INPUT
96   VDDQ   POWER
97   ACT_n   INPUT
98   VDD   POWER
99   VREFCA   POWER
100   VSS   GND
101   DNU   NC
102   VSS   GND
103   A10   INPUT
104   BG0   INPUT
105   BA0   INPUT
106   VDD   POWER
107   A4   INPUT
108   RESET   RESET
109   A6   INPUT
110   DNU   NC
111   DNU   NC
112   DNU   NC
113   A0   INPUT
114   DNU   NC
115   A8   INPUT
116   A2   INPUT
117   A11   INPUT
118   PARITY   INPUT
|**********************DIFF PIN*********************************************
[Diff_pin]   inv_pin   vdiff   tdelay_typ   tdelay_min   tdelay_max
   27   26   0.250V   0ns   NA   NA
   81   79   0.000V   0ns   NA   NA
   56   57   0.000V   0ns   NA   NA
|   Model Selector
[Model Selector] DQ
DQ_34_2666   34 Ohm Data I/O with no ODT, 1600-2666Mbps
DQ_40_2666   40 Ohm Data I/O with no ODT, 1600-2666Mbps
DQ_48_2666   48 Ohm Data I/O with no ODT, 1600-2666Mbps
DQ_IN_ODT34_2666   Data Input with 34ohm ODT, 1600-2666Mbps
DQ_IN_ODT40_2666   Data Input with 40ohm ODT, 1600-2666Mbps
DQ_IN_ODT48_2666   Data Input with 48ohm ODT, 1600-2666Mbps
DQ_IN_ODT60_2666   Data Input with 60ohm ODT, 1600-2666Mbps
DQ_IN_ODT80_2666   Data Input with 80ohm ODT, 1600-2666Mbps
DQ_IN_ODT120_2666  Data Input with 120ohm ODT, 1600-2666Mbps
DQ_IN_ODT240_2666  Data Input with 240ohm ODT, 1600-2666Mbps
DQ_34_3200   34 Ohm Data I/O with no ODT, 2933/3200Mbps
DQ_40_3200   40 Ohm Data I/O with no ODT, 2933/3200Mbps
DQ_48_3200   48 Ohm Data I/O with no ODT, 2933/3200Mbps
DQ_IN_ODT34_3200   Data Input with 34ohm ODT, 2933/3200Mbps
DQ_IN_ODT40_3200   Data Input with 40ohm ODT, 2933/3200Mbps
DQ_IN_ODT48_3200   Data Input with 48ohm ODT, 2933/3200Mbps
DQ_IN_ODT60_3200   Data Input with 60ohm ODT, 2933/3200Mbps
DQ_IN_ODT80_3200   Data Input with 80ohm ODT, 2933/3200Mbps
DQ_IN_ODT120_3200  Data Input with 120ohm ODT, 2933/3200Mbps
DQ_IN_ODT240_3200  Data Input with 240ohm ODT, 2933/3200Mbps
[Model Selector] DQS
DQS_34_2666   34 Ohm Data Strobe I/O with no ODT, 1600-2666Mbps
DQS_40_2666   40 Ohm Data Strobe I/O with no ODT, 1600-2666Mbps
DQS_48_2666   48 Ohm Data Strobe I/O with no ODT, 1600-2666Mbps
DQS_IN_ODT34_2666  Data Strobe Input with 34ohm ODT, 1600-2666Mbps
DQS_IN_ODT40_2666  Data Strobe Input with 40ohm ODT, 1600-2666Mbps
DQS_IN_ODT48_2666  Data Strobe Input with 48ohm ODT, 1600-2666Mbps
DQS_IN_ODT60_2666  Data Strobe Input with 60ohm ODT, 1600-2666Mbps
DQS_IN_ODT80_2666  Data Strobe Input with 80ohm ODT, 1600-2666Mbps
DQS_IN_ODT120_2666 Data Strobe Input with 120ohm ODT, 1600-2666Mbps
DQS_IN_ODT240_2666 Data Strobe Input with 240ohm ODT, 1600-2666Mbps
DQS_34_3200   34 Ohm Data Strobe I/O with no ODT, 2933/3200Mbps
DQS_40_3200   40 Ohm Data Strobe I/O with no ODT, 2933/3200Mbps
DQS_48_3200   48 Ohm Data Strobe I/O with no ODT, 2933/3200Mbps
DQS_IN_ODT34_3200  Data Strobe Input with 34ohm ODT, 2933/3200Mbps
DQS_IN_ODT40_3200  Data Strobe Input with 40ohm ODT, 2933/3200Mbps
DQS_IN_ODT48_3200  Data Strobe Input with 48ohm ODT, 2933/3200Mbps
DQS_IN_ODT60_3200  Data Strobe Input with 60ohm ODT, 2933/3200Mbps
DQS_IN_ODT80_3200  Data Strobe Input with 80ohm ODT, 2933/3200Mbps
DQS_IN_ODT120_3200 Data Strobe Input with 120ohm ODT, 2933/3200Mbps
DQS_IN_ODT240_3200 Data Strobe Input with 240ohm ODT, 2933/3200Mbps
[Model Selector] DM_DBI
DM_INPUT_2666   DM Input Model with no ODT, 1600-2666Mbps
DM_ODT34_2666   DM Input Model with 34ohm ODT, 1600-2666Mbps
DM_ODT40_2666   DM Input Model with 40ohm ODT, 1600-2666Mbps
DM_ODT48_2666   DM Input Model with 48ohm ODT, 1600-2666Mbps
DM_ODT60_2666   DM Input Model with 60ohm ODT, 1600-2666Mbps
DM_ODT80_2666   DM Input Model with 80ohm ODT, 1600-2666Mbps
DM_ODT120_2666   DM Input Model with 120ohm ODT, 1600-2666Mbps
DM_ODT240_2666   DM Input Model with 240ohm ODT, 1600-2666Mbps
DM_INPUT_3200   DM Input Model with no ODT, 2933/3200Mbps
DM_ODT34_3200   DM Input Model with 34ohm ODT, 2933/3200Mbps
DM_ODT40_3200   DM Input Model with 40ohm ODT, 2933/3200Mbps
DM_ODT48_3200   DM Input Model with 48ohm ODT, 2933/3200Mbps
DM_ODT60_3200   DM Input Model with 60ohm ODT, 2933/3200Mbps
DM_ODT80_3200   DM Input Model with 80ohm ODT, 2933/3200Mbps
DM_ODT120_3200   DM Input Model with 120ohm ODT, 2933/3200Mbps
DM_ODT240_3200   DM Input Model with 240ohm ODT, 2933/3200Mbps
DQ_34_2666   34 Ohm DBI I/O with no ODT, 1600-2666Mbps
DQ_40_2666   40 Ohm DBI I/O with no ODT, 1600-2666Mbps
DQ_48_2666   48 Ohm DBI I/O with no ODT, 1600-2666Mbps
DQ_IN_ODT34_2666   DBI Input with 34ohm ODT, 1600-2666Mbps
DQ_IN_ODT40_2666   DBI Input with 40ohm ODT, 1600-2666Mbps
DQ_IN_ODT48_2666   DBI Input with 48ohm ODT, 1600-2666Mbps
DQ_IN_ODT60_2666   DBI Input with 60ohm ODT, 1600-2666Mbps
DQ_IN_ODT80_2666   DBI Input with 80ohm ODT, 1600-2666Mbps
DQ_IN_ODT120_2666  DBI Input with 120ohm ODT, 1600-2666Mbps
DQ_IN_ODT240_2666  DBI Input with 240ohm ODT, 1600-2666Mbps
DQ_34_3200   34 Ohm DBI I/O with no ODT, 2933/3200Mbps
DQ_40_3200   40 Ohm DBI I/O with no ODT, 2933/3200Mbps
DQ_48_3200   48 Ohm DBI I/O with no ODT, 2933/3200Mbps
DQ_IN_ODT34_3200   DBI Input with 34ohm ODT, 2933/3200Mbps
DQ_IN_ODT40_3200   DBI Input with 40ohm ODT, 2933/3200Mbps
DQ_IN_ODT48_3200   DBI Input with 48ohm ODT, 2933/3200Mbps
DQ_IN_ODT60_3200   DBI Input with 60ohm ODT, 2933/3200Mbps
DQ_IN_ODT80_3200   DBI Input with 80ohm ODT, 2933/3200Mbps
DQ_IN_ODT120_3200  DBI Input with 120ohm ODT, 2933/3200Mbps
DQ_IN_ODT240_3200  DBI Input with 240ohm ODT, 2933/3200Mbps
NF_INPUT   Non-Functioning Terminator Model
[Model Selector] DM_DBI_TDQS
DM_INPUT_2666   DM Input Model with no ODT, 1600-2666Mbps
DM_ODT34_2666   DM Input Model with 34ohm ODT, 1600-2666Mbps
DM_ODT40_2666   DM Input Model with 40ohm ODT, 1600-2666Mbps
DM_ODT48_2666   DM Input Model with 48ohm ODT, 1600-2666Mbps
DM_ODT60_2666   DM Input Model with 60ohm ODT, 1600-2666Mbps
DM_ODT80_2666   DM Input Model with 80ohm ODT, 1600-2666Mbps
DM_ODT120_2666   DM Input Model with 120ohm ODT, 1600-2666Mbps
DM_ODT240_2666   DM Input Model with 240ohm ODT, 1600-2666Mbps
DM_INPUT_3200   DM Input Model with no ODT, 2933/3200Mbps
DM_ODT34_3200   DM Input Model with 34ohm ODT, 2933/3200Mbps
DM_ODT40_3200   DM Input Model with 40ohm ODT, 2933/3200Mbps
DM_ODT48_3200   DM Input Model with 48ohm ODT, 2933/3200Mbps
DM_ODT60_3200   DM Input Model with 60ohm ODT, 2933/3200Mbps
DM_ODT80_3200   DM Input Model with 80ohm ODT, 2933/3200Mbps
DM_ODT120_3200   DM Input Model with 120ohm ODT, 2933/3200Mbps
DM_ODT240_3200   DM Input Model with 240ohm ODT, 2933/3200Mbps
DQ_34_2666   34 Ohm DBI I/O with no ODT, 1600-2666Mbps
DQ_40_2666   40 Ohm DBI I/O with no ODT, 1600-2666Mbps
DQ_48_2666   48 Ohm DBI I/O with no ODT, 1600-2666Mbps
DQ_IN_ODT34_2666   DBI Input with 34ohm ODT, 1600-2666Mbps
DQ_IN_ODT40_2666   DBI Input with 40ohm ODT, 1600-2666Mbps
DQ_IN_ODT48_2666   DBI Input with 48ohm ODT, 1600-2666Mbps
DQ_IN_ODT60_2666   DBI Input with 60ohm ODT, 1600-2666Mbps
DQ_IN_ODT80_2666   DBI Input with 80ohm ODT, 1600-2666Mbps
DQ_IN_ODT120_2666  DBI Input with 120ohm ODT, 1600-2666Mbps
DQ_IN_ODT240_2666  DBI Input with 240ohm ODT, 1600-2666Mbps
DQ_34_3200   34 Ohm DBI I/O with no ODT, 2933/3200Mbps
DQ_40_3200   40 Ohm DBI I/O with no ODT, 2933/3200Mbps
DQ_48_3200   48 Ohm DBI I/O with no ODT, 2933/3200Mbps
DQ_IN_ODT34_3200   DBI Input with 34ohm ODT, 2933/3200Mbps
DQ_IN_ODT40_3200   DBI Input with 40ohm ODT, 2933/3200Mbps
DQ_IN_ODT48_3200   DBI Input with 48ohm ODT, 2933/3200Mbps
DQ_IN_ODT60_3200   DBI Input with 60ohm ODT, 2933/3200Mbps
DQ_IN_ODT80_3200   DBI Input with 80ohm ODT, 2933/3200Mbps
DQ_IN_ODT120_3200  DBI Input with 120ohm ODT, 2933/3200Mbps
DQ_IN_ODT240_3200  DBI Input with 240ohm ODT, 2933/3200Mbps
TDQS_ODT34_2666   TDQS Terminator Model with 34ohm ODT, 1600-2666Mbps
TDQS_ODT40_2666   TDQS Terminator Model with 40ohm ODT, 1600-2666Mbps
TDQS_ODT48_2666   TDQS Terminator Model with 48ohm ODT, 1600-2666Mbps
TDQS_ODT60_2666   TDQS Terminator Model with 60ohm ODT, 1600-2666Mbps
TDQS_ODT80_2666   TDQS Terminator Model with 80ohm ODT, 1600-2666Mbps
TDQS_ODT120_2666   TDQS Terminator Model with 120ohm ODT, 1600-2666Mbps
TDQS_ODT240_2666   TDQS Terminator Model with 240ohm ODT, 1600-2666Mbps
TDQS_ODT34_3200   TDQS Terminator Model with 34ohm ODT, 2933/3200Mbps
TDQS_ODT40_3200   TDQS Terminator Model with 40ohm ODT, 2933/3200Mbps
TDQS_ODT48_3200   TDQS Terminator Model with 48ohm ODT, 2933/3200Mbps
TDQS_ODT60_3200   TDQS Terminator Model with 60ohm ODT, 2933/3200Mbps
TDQS_ODT80_3200   TDQS Terminator Model with 80ohm ODT, 2933/3200Mbps
TDQS_ODT120_3200   TDQS Terminator Model with 120ohm ODT, 2933/3200Mbps
TDQS_ODT240_3200   TDQS Terminator Model with 240ohm ODT, 2933/3200Mbps
NF_INPUT   Non-Functioning Terminator Model
[Model Selector] NF_TDQS
NF_INPUT   Non-Functioning Terminator Model
TDQS_ODT34_2666   TDQS Terminator Model with 34ohm ODT, 1600-2666Mbps
TDQS_ODT40_2666   TDQS Terminator Model with 40ohm ODT, 1600-2666Mbps
TDQS_ODT48_2666   TDQS Terminator Model with 48ohm ODT, 1600-2666Mbps
TDQS_ODT60_2666   TDQS Terminator Model with 60ohm ODT, 1600-2666Mbps
TDQS_ODT80_2666   TDQS Terminator Model with 80ohm ODT, 1600-2666Mbps
TDQS_ODT120_2666   TDQS Terminator Model with 120ohm ODT, 1600-2666Mbps
TDQS_ODT240_2666   TDQS Terminator Model with 240ohm ODT, 1600-2666Mbps
TDQS_ODT34_3200   TDQS Terminator Model with 34ohm ODT, 2933/3200Mbps
TDQS_ODT40_3200   TDQS Terminator Model with 40ohm ODT, 2933/3200Mbps
TDQS_ODT48_3200   TDQS Terminator Model with 48ohm ODT, 2933/3200Mbps
TDQS_ODT60_3200   TDQS Terminator Model with 60ohm ODT, 2933/3200Mbps
TDQS_ODT80_3200   TDQS Terminator Model with 80ohm ODT, 2933/3200Mbps
TDQS_ODT120_3200   TDQS Terminator Model with 120ohm ODT, 2933/3200Mbps
TDQS_ODT240_3200   TDQS Terminator Model with 240ohm ODT, 2933/3200Mbps
[Model Selector] INPUT
INPUT_2666   Add/Cmd/Ctrl Input Model, 1600-2666Mbps
INPUT_3200   Add/Cmd/Ctrl Input Model, 2933/3200Mbps
[Model Selector] CLKIN
CLKIN_2666   Clock Input Model, 1600-2666Mbps
CLKIN_3200   Clock Input Model, 2933/3200Mbps
[Model Selector] ALERT
ALERT_2666   ALERT_n Output Model, 1600-2666Mbps
ALERT_3200   ALERT_n Output Model, 2933/3200Mbps
| Sparse Matrix Package Model for z90b_78ball_pkg (x8)
[Define Package Model] z90b_78ball_pkg
[Manufacturer]   Micron Technology, Inc.
[OEM]   Micron Technology, Inc.
[Description]   78-Ball FBGA package model for z90b
[Number of Pins] 53
[Pin Numbers]
A1  | VDD_SUBNET_0
A3  | TDQS-C
A7  | DM#
A9  | VSS
B1  | VPP-B1
B2  | VDDQ_SUBNET_0
B3  | DQS-C
B7  | DQ1
B8  | VDDQ_SUBNET_1
B9  | ZQ
C2  | DQ0
C3  | DQS-T
C7  | VDD_SUBNET_1
D2  | DQ4
D3  | DQ2
D7  | DQ3
D8  | DQ5
E3  | DQ6
E7  | DQ7
F1  | VDDDLL
F3  | ODT
F7  | CLK-T
F8  | CLK-C
G3  | CKE
G7  | CS#
G9  | TEN
H2  | WE#
H3  | ACT#
H7  | CAS#
H8  | RAS#
J1  | VREFCA
J2  | BG0
J3  | A10
J7  | A12
J8  | BG1
K2  | BA0
K3  | A4
K7  | A3
K8  | BA1
L1  | RESET#
L2  | A6
L3  | A0
L7  | A1
L8  | A5
L9  | ALERT#
M2  | A8
M3  | A2
M7  | A9
M8  | A7
M9  | VPP-M9
N2  | A11
N3  | PAR
N8  | A13
[Model Data]
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[End Model Data]
[End Package Model]
| Sparse Matrix Package Model for z90b_96ball_pkg (x16)
[Define Package Model] z90b_96ball_pkg
[Manufacturer]   Micron Technology, Inc.
[OEM]   Micron Technology, Inc.
[Description]   96-Ball FBGA package model for z90b
[Number of Pins] 68
[Pin Numbers]
A1  | VDDQ_SUBNET_0
A2  | VSS_SUBNET_0
A3  | DQ8
A7  | UDQS-C
B1  | VPP-B1
B3  | VDD_SUBNET_2
B7  | UDQS-T
B8  | DQ9
C1  | VDDQ_SUBNET_1
C2  | DQ12
C3  | DQ10
C7  | DQ11
C8  | DQ13
D1  | VDD_SUBNET_0
D2  | VSS_SUBNET_2
D3  | DQ14
D7  | DQ15
E2  | UDM#
E3  | VSS_SUBNET_1
E7  | LDM#
F3  | LDQS-C
F7  | DQ1
F9  | ZQ
G2  | DQ0
G3  | LDQS-T
G7  | VDD_SUBNET_3
H2  | DQ4
H3  | DQ2
H7  | DQ3
H8  | DQ5
J1  | VDDDLL
J3  | DQ6
J7  | DQ7
K1  | VSSDLL
K2  | CKE
K3  | ODT
K7  | CLK-T
K8  | CLK-C
L1  | VDD_SUBNET_1
L2  | WE#
L3  | ACT#
L7  | CS#
L8  | RAS#
M1  | VREFCA
M2  | BG0
M3  | A10
M7  | A12
M8  | CAS#
N2  | BA0
N3  | A4
N7  | A3
N8  | BA1
N9  | TEN
P1  | RESET#
P2  | A6
P3  | A0
P7  | A1
P8  | A5
P9  | ALERT#
R1  | VDD_SUBNET_4
R2  | A8
R3  | A2
R7  | A9
R8  | A7
R9  | VPP-R9
T2  | A11
T3  | PAR
T8  | A13
[Model Data]
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[End Model Data]
[End Package Model]
| Models and submodels in the file (93): DQ_34_2666 (I/O), DQ_40_2666 (I/O), DQ_48_2666 (I/O), DQ_IN_ODT34_2666 (Input), DQ_IN_ODT40_2666 (Input), DQ_IN_ODT48_2666 (Input), DQ_IN_ODT60_2666 (Input), DQ_IN_ODT80_2666 (Input), DQ_IN_ODT120_2666 (Input), DQ_IN_ODT240_2666 (Input), DQ_34_3200 (I/O), DQ_40_3200 (I/O), DQ_48_3200 (I/O), DQ_IN_ODT34_3200 (Input), DQ_IN_ODT40_3200 (Input), DQ_IN_ODT48_3200 (Input), DQ_IN_ODT60_3200 (Input), DQ_IN_ODT80_3200 (Input), DQ_IN_ODT120_3200 (Input), DQ_IN_ODT240_3200 (Input), DQS_34_2666 (I/O), DQS_40_2666 (I/O), DQS_48_2666 (I/O), DQS_IN_ODT34_2666 (Input), DQS_IN_ODT40_2666 (Input), DQS_IN_ODT48_2666 (Input), DQS_IN_ODT60_2666 (Input), DQS_IN_ODT80_2666 (Input), DQS_IN_ODT120_2666 (Input), DQS_IN_ODT240_2666 (Input), DQS_34_3200 (I/O), DQS_40_3200 (I/O), DQS_48_3200 (I/O), DQS_IN_ODT34_3200 (Input), DQS_IN_ODT40_3200 (Input), DQS_IN_ODT48_3200 (Input), DQS_IN_ODT60_3200 (Input), DQS_IN_ODT80_3200 (Input), DQS_IN_ODT120_3200 (Input), DQS_IN_ODT240_3200 (Input), DM_INPUT_2666 (Input), DM_ODT34_2666 (Input), DM_ODT40_2666 (Input), DM_ODT48_2666 (Input), DM_ODT60_2666 (Input), DM_ODT80_2666 (Input), DM_ODT120_2666 (Input), DM_ODT240_2666 (Input), DM_INPUT_3200 (Input), DM_ODT34_3200 (Input), DM_ODT40_3200 (Input), DM_ODT48_3200 (Input), DM_ODT60_3200 (Input), DM_ODT80_3200 (Input), DM_ODT120_3200 (Input), DM_ODT240_3200 (Input), TDQS_ODT34_2666 (Terminator), TDQS_ODT40_2666 (Terminator), TDQS_ODT48_2666 (Terminator), TDQS_ODT60_2666 (Terminator), TDQS_ODT80_2666 (Terminator), TDQS_ODT120_2666 (Terminator), TDQS_ODT240_2666 (Terminator), TDQS_ODT34_3200 (Terminator), TDQS_ODT40_3200 (Terminator), TDQS_ODT48_3200 (Terminator), TDQS_ODT60_3200 (Terminator), TDQS_ODT80_3200 (Terminator), TDQS_ODT120_3200 (Terminator), TDQS_ODT240_3200 (Terminator), INPUT_2666 (Input), INPUT_3200 (Input), CLKIN_2666 (Input), CLKIN_3200 (Input), RESET (Input), TEN (Input), ALERT_2666 (Open_sink), ALERT_3200 (Open_sink), NF_INPUT (Terminator), 34ohm_ODT_2666 (Dynamic_clamp)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
